* Power-on / power-off mute control (master spec section 8), v5 = values in tools/gen_master.py (master v0.14).
* v5 (2026-10-29, RV9b): 4.7K base-emitter on the driver (RBE); the -V-lost case with the +0.45 V clamp and the
* comparators' V_OL corner is sim/review/clicks/mute_rbe.cir.
* v4 (2026-10-29, review of docs/proposals/clicks_proposal.md RV9): comparator B's + input on SENSE_REF = +1.0 V (51K / 10K from
* VREF6) and its lower leg 64.9K (trip -14.3 V); case 4 takes -V to 0 V as before (the +0.45 V clamp case and the
* relay driver's base is sim/review/clicks/mute_rbe.cir).
* v3 (2026-10-23, docs/reviews/master_parts_review.md item 3): reset and fast-release resistors 2.2K -> 4.7K (one LM393 output
* sank ~23 mA at a one-rail loss); six coils (K6 phones).
* v1 (first generator draft: 220K / 22u timer, 1M hysteresis, unlimited diode paths) never closed within 4 s:
* the 1M from the Schmitt output held the timer near 10.4 V, so it crawled towards the 6.2 V threshold.
* Six G6K-2F-Y DC12 coils (1315 R, inductance assumed 1 H) with 560R each from +VBUS, MMBT3904 low-side.
* LM393: open-collector model, emitter on -VL, sinks up to 16 mA, works above 2 V total supply.
* Cases: 1 power-up; 2 power-down; 3 +V lost; 4 -V lost; 5 20 ms dip to 12 V; 6 slow 2 s ramp.
.param tr=50m tp=1e9 tn=1e9 dip=0
.model DZ62 D(BV=6.2 IBV=5m IS=1e-14 RS=10)
.model D1N4148 D(IS=2.52n RS=0.568 N=1.752 CJO=4p M=0.4 TT=20n BV=100)
.model Q3904 NPN(IS=6.734f XTI=3 EG=1.11 VAF=74.03 BF=416.4 NE=1.259 ISE=6.734f IKF=66.78m XTB=1.5 BR=.7371
+ NC=2 ISC=0 IKR=0 RC=1 CJC=3.638p MJC=.3085 VJC=.75 FC=.5 CJE=4.493p MJE=.2593 VJE=.75 TR=239.5n TF=301.2p ITF=.4 VTF=4 XTF=2 RB=10)
.subckt CMP inp inn out vp vn
* sink when inn > inp, only with > 2 V across the supply pins
B1 out vn I = 0.25*(1+tanh(1e3*(V(inn)-V(inp))))*(1+tanh(5*(V(vp)-V(vn)-2)))*16m*tanh((V(out)-V(vn))/0.8)
COUT out 0 10p
.ends
* ---------------- rails (PSU after its regulators): ramp up over tr, collapse over 200 ms at tp / tn, optional dip
BVP vbp 0 V = 17*min(time/{tr},1)*max(0,min(1,1-(time-{tp})/0.2))*(1-{dip}*(5/17)*(time>3)*(time<3.02))
BVN vbn 0 V = -17*min(time/{tr},1)*max(0,min(1,1-(time-{tn})/0.2))*(1-{dip}*(5/17)*(time>3)*(time<3.02))
* ---------------- logic branch: 10R + 47u per rail, ~17 mA load (LEDs, comparators)
RLP vbp vlp 10
CLP vlp 0 47u
RLLP vlp 0 1k
RLN vbn vln 10
CLN vln 0 47u
RLLN vln 0 1k
* ---------------- reference and rail sense
RZ vbp vref 4.7k
DZ1 0 vref DZ62
R56 vbp sp 56k
R47 sp 0 47k
R22 vref sn 22k
R51 sn vbn 64.9k
R238 vref sref 51k
R239 sref 0 10k
XA sp vref rok vlp vln CMP
XB sref sn rok vlp vln CMP
RPU vlp rok 10k
* ---------------- timer (2.2M / 2.2u film, clamped at -0.7 V, reset through 4.7K), Schmitt (22M), driver
RT rok mt 2.2meg
CT mt 0 2.2u
DT mt dtx D1N4148
RDT dtx rok 4.7k
DCT 0 mt D1N4148
XC mt vref go vlp vln CMP
RH go mt 22meg
RGO vlp go 4.7k
RB go b 4.7k
DF b dfx D1N4148
RDF dfx rok 4.7k
DCL 0 b D1N4148
Q1 drv b 0 Q3904
RBE b 0 4.7k
* ---------------- six relay coils
.subckt COIL top drv
RS top c 560
RW c m 1315
LW m drv 1
DFW drv c D1N4148
.ends
XK1 vbp drv COIL
XK2 vbp drv COIL
XK3 vbp drv COIL
XK4 vbp drv COIL
XK5 vbp drv COIL
XK6 vbp drv COIL
* coil current of one relay
BIK ik 0 V = (V(XK1.c) - V(XK1.m)) / 1315
.control
set noaskquit
* must operate: 80 % of 12 V = 9.6 V -> 7.30 mA; must release: 10 % -> 0.91 mA
let k = 1
while k <= 6
  alterparam tr=50m
  alterparam tp=1e9
  alterparam tn=1e9
  alterparam dip=0
  if k = 2
    alterparam tp=3
    alterparam tn=3
  end
  if k = 3
    alterparam tp=3
  end
  if k = 4
    alterparam tn=3
  end
  if k = 5
    alterparam dip=1
  end
  if k = 6
    alterparam tr=2
  end
  reset
  if k = 5
    tran 200u 8 0 1m
  else
    if k = 6
      tran 200u 6 0 1m
    else
      tran 200u 4 0 1m
    end
  end
  meas tran glitch max v(ik) from=0 to=1.5
  meas tran tclose when v(ik)=7.3m rise=1
  echo "case $&k: max coil current before 1.5 s = $&glitch A; first closes at $&tclose s"
  if k >= 2
    if k <= 5
      meas tran topen when v(ik)=0.91m fall=1 td=2.9
      meas tran vpat find v(vbp) at=$&topen
      meas tran vnat find v(vbn) at=$&topen
      echo "        opens at $&topen s, rails then +$&vpat / $&vnat V"
    end
  end
  if k = 5
    meas tran treclose when v(ik)=7.3m rise=2
    echo "        recloses at $&treclose s (dip ended 3.02 s)"
  end
  if k = 6
    meas tran t14 when v(vbp)=14 rise=1
    echo "        (+V reached 14 V at $&t14 s)"
  end
  let k = k + 1
end
.endc
.end
